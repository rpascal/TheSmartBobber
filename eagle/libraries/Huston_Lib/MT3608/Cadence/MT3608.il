defun( AFn_OpenDesign (@key design, (mode "w"), noMru, noConfirm, forceNew)
 let((noconfirmStatus, result)
  when(noConfirm, noconfirmStatus = axlGetVariable("NOCONFIRM"), axlSetVariable("NOCONFIRM", t))
  when(forceNew && isFile(design), deleteFile(design))
  result = if(noMru && axlVersion('version) >= 16.0
   then axlOpenDesign(?design design, ?mode mode, ?noMru t)
   else axlOpenDesign(?design design, ?mode mode)
  )
  when(noConfirm, if(noconfirmStatus then axlSetVariable("NOCONFIRM", t) else axlUnsetVariable("NOCONFIRM")))
  result
))
procedure( CreatePadstacks()
    axlDBChangeDesignUnits("millimeters" 4)
    pad_list0 = cons(make_axlPadStackPad(
        ?layer "TOP", ?type 'REGULAR,
        ?figure 'RECTANGLE, ?figureSize 0.6:1.2) nil)
    ps_id = axlDBCreatePadStack("r120_60", nil, pad_list0 t)
    axlPadstackToDisk("r120_60")
)
procedure( BuildFootprint()
    AFn_OpenDesign(?design strcat("SOT95P280X145-6N", ".dra"), ?mode "wf", ?noMru t, ?noConfirm t, ?forceNew t)
    axlSetSymbolType("package")
    mytext = make_axlTextOrientation(?textBlock 6, ?rotation 0, ?mirrored nil, ?justify "center")
    mypin = make_axlPinText(?number "1", ?offset 0:0, ?text mytext)
    axlDBCreatePin("r120_60" 98.75:100.95 mypin 90)
    mypin = make_axlPinText(?number "2", ?offset 0:0, ?text mytext)
    axlDBCreatePin("r120_60" 98.75:100 mypin 90)
    mypin = make_axlPinText(?number "3", ?offset 0:0, ?text mytext)
    axlDBCreatePin("r120_60" 98.75:99.05 mypin 90)
    mypin = make_axlPinText(?number "4", ?offset 0:0, ?text mytext)
    axlDBCreatePin("r120_60" 101.25:99.05 mypin 90)
    mypin = make_axlPinText(?number "5", ?offset 0:0, ?text mytext)
    axlDBCreatePin("r120_60" 101.25:100 mypin 90)
    mypin = make_axlPinText(?number "6", ?offset 0:0, ?text mytext)
    axlDBCreatePin("r120_60" 101.25:100.95 mypin 90)
    axlDBCreateText("U*" 100:100 "2" "REF DES/SILKSCREEN_TOP")
    axlDBCreateLine((list 97.9:101.75 102.1:101.75), 0.05, "PACKAGE GEOMETRY/PLACE_BOUND_TOP")
    axlDBCreateLine((list 102.1:101.75 102.1:98.25), 0.05, "PACKAGE GEOMETRY/PLACE_BOUND_TOP")
    axlDBCreateLine((list 102.1:98.25 97.9:98.25), 0.05, "PACKAGE GEOMETRY/PLACE_BOUND_TOP")
    axlDBCreateLine((list 97.9:98.25 97.9:101.75), 0.05, "PACKAGE GEOMETRY/PLACE_BOUND_TOP")
    axlDBCreateLine((list 99.2:101.45 100.8:101.45), 0.1, "PACKAGE GEOMETRY/ASSEMBLY_TOP")
    axlDBCreateLine((list 100.8:101.45 100.8:98.55), 0.1, "PACKAGE GEOMETRY/ASSEMBLY_TOP")
    axlDBCreateLine((list 100.8:98.55 99.2:98.55), 0.1, "PACKAGE GEOMETRY/ASSEMBLY_TOP")
    axlDBCreateLine((list 99.2:98.55 99.2:101.45), 0.1, "PACKAGE GEOMETRY/ASSEMBLY_TOP")
    axlDBCreateLine((list 99.2:100.5 100.15:101.45), 0.1, "PACKAGE GEOMETRY/ASSEMBLY_TOP")
    axlDBCreateLine((list 99.7:101.45 100.3:101.45), 0.2, "PACKAGE GEOMETRY/SILKSCREEN_TOP")
    axlDBCreateLine((list 100.3:101.45 100.3:98.55), 0.2, "PACKAGE GEOMETRY/SILKSCREEN_TOP")
    axlDBCreateLine((list 100.3:98.55 99.7:98.55), 0.2, "PACKAGE GEOMETRY/SILKSCREEN_TOP")
    axlDBCreateLine((list 99.7:98.55 99.7:101.45), 0.2, "PACKAGE GEOMETRY/SILKSCREEN_TOP")
    axlDBCreateLine((list 98.15:101.6 99.35:101.6), 0.2, "PACKAGE GEOMETRY/SILKSCREEN_TOP")
    ;axlCompileSymbol(?symbol "SOT95P280X145-6N", ?type "package")
    axlSaveDesign(?noMru t)
)
